defun(loadLiyuanMenu (t_menuName)    						; loadUniNavMenu是函数名，建议取独一无二的名字。
	SKILLToolsMenu = '(
            (popup "\316\322\265\304\271\244\276\337")    	;主菜单的名字：我的工具
			;("quick_view","quick_view")    		;前面一个"quick_view"是下一级子菜单名，后一个"quick_view"是我们调用skill所用的指令。以下相同不赘述
			;("Skill\326\330\324\330[\265\367\312\324\323\303]","skill_load")	;Skill重载(调试用)
			("\266\324\306\353\271\244\276\337","al")						;对齐工具
			("PIN\266\324\306\353","ali_pin")								;pin对齐
			("\327\324\266\257\320\375\327\252\316\273\272\305[\320\375\327\252\307\260\317\310\261\243\264\346]","ch_ref")	;自动位号旋转
			("\327\324\266\257\271\351\326\320\316\273\272\305[\277\362\321\241\272\363Done]","mc_ref")						;自动位号居中
			("\307\320\270\356\317\337/\315\255\306\244","cut")			;切割工具

			(separator)    ;这里是分割线
			("[\260\264\312\261\274\344\261\243\264\346]","wxsf")  			;按时间保存

			(separator)    ;这里是分割线
			("\270\361\265\343\311\350\326\303","quick_grids")					;格点设置
			("\322\273\274\374\263\365\312\274\311\350\326\303","setupall")			;初始设置

			(separator)    ;这里是分割线
				("\266\317\315\267\317\337/\315\255/\271\375\277\327 \274\354\262\351","quick_dangling")	;断头线/铜/过孔 检查
				("\270\337\301\301\316\336\315\370\302\347PIN"	 "hl_null_pin")			;高亮无网络PIN
				("REF DES \310\261\312\247\274\354\262\351","Ch_NoRef")					;检查无位号器件
				(popup "\266\324\261\310\301\275\270\366brd\316\304\274\376")	;brd对比
					("\266\324\261\310\315\370\261\355","cn")						;对比网表
					("\266\324\261\310\306\367\274\376","cs")						;对比器件
					(end)
				("3D\270\337\266\310\274\354\262\351","heightchk")						;检查器件高度

			(separator)    ;这里是分割线
				(popup "\265\274\263\366\275\341\271\271")	;导出结构
					("1.\265\261\307\260\317\324\312\276[DXF]","exportcurrent")		;导出当前DXF
					("2.\325\375\267\264\313\277\323\241[DXF]","exporttopbotdxf")	;导出2D位号
					("3.\275\341\271\271\310\267\310\317[2D+3D]","exportjiegou")	;导出2D+3D+文件整理
					(end)
				(popup "\265\274\263\366Lib")				;导出库工具
					("\271\244\276\3371[\321\241\326\320]"	 "libbypick")										;导出库工具1
					("\271\244\276\3372[\277\311\265\274\263\366\267\342\327\260\304\332Pad]"	 "dumplib")		;导出库工具2
					(end)
				("\265\274\263\366asc[\326\273\323\320\306\367\274\376\262\274\276\326]"	 "atp")	 							;转PADS

			(separator)    ;这里是分割线
				("\265\245\316\273\327\252\273\273"	 "conv")	 										;单位转换
				("[\326\320\316\304\327\2528\275\370\326\306\264\372\302\353]"	 "zwen")				;转中文八进制代码
				;("\261\352\274\307STEP\304\243\320\315", "step pkg map")								;step模型
				("\300\254\273\370\316\304\274\376\327\324\266\257\325\373\300\355" "file_autoclear")  	;垃圾文件自动清理
			(end)

				/* 注释
                        ;(popup "Change")  ;需要创建下一级子菜单Change
                                ;("replace_via","replace_via")  ;在Change下创建下一级菜单
                                ;("change_net_onvias","change_net_onvias")
                                ;("change_lw","clw")
                        ;(end)  ;返回上一级菜单，每进一级菜单，要返回上一级都要有(end)

                        ;(popup "Check")
                                ;("check_dir","check_dir")
                                ;("orphannet","orphannet")
                                ;("ch_text_overlap","ch_text_overlap")
                                ;("check_line90","line90")
                        ;(end)
                ;(end)  ;返回根菜单
				*/
        )
	procedure(loadLiyuanMenu(tMenuFile)
        let((xMenuID)
                when(tMenuFile == "allegro" ;只判斷第一次載入及執行,如果沒有此判斷的話,有其他程式也是使用動態選單時,就會再加載一次
                        xMenuID = axlUIMenuFind(nil -1)
                        axlUIMenuInsert(xMenuID SKILLToolsMenu)
                )
        )
)
        let( (palMenu)
                palMenu = axlUIMenuFind(nil -1)
                axlUIMenuInsert(palMenu SKILLToolsMenu)
        )
)
axlTriggerSet('menu 'loadLiyuanMenu)  ;这里 loadUniNavMenu需要和上边函数名相同。
