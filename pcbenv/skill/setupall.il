axlCmdRegister("setupall" 'setupall ?cmdType "general")	;注册命令

defun(	setupall ()
	;创建一键设置的脚本文件：setupall.scr
	p = outfile("setupall.scr\n")
		fprintf(p "setwindow pcb\n")
		fprintf(p "generaledit\n")
		;设置显示
		fprintf(p "prmed\n")
		fprintf(p "setwindow form.prmedit\n")
		fprintf(p "FORM prmedit display_plated_holes YES \n")
		fprintf(p "FORM prmedit display_non_plated_holes YES \n")
		fprintf(p "FORM prmedit display_enhance YES\n")
		fprintf(p "FORM prmedit design  \n")
		;设置单位
		fprintf(p "FORM prmedit units Millimeter \n")
		;设置视图大小
		fprintf(p "FORM prmedit x -500.0000  \n")
		fprintf(p "FORM prmedit width 1000.0000 \n")
		fprintf(p "FORM prmedit height 1000.0000 \n")
		fprintf(p "FORM prmedit y -500.0000  \n")
		fprintf(p "FORM prmedit done  \n")
		fprintf(p "setwindow pcb\n")
		;设置格点
		fprintf(p "define grid \n")
		fprintf(p "setwindow form.grid\n")
		fprintf(p "FORM grid non_etch non_etch_x_grids 0.01 \n")
		fprintf(p "FORM grid non_etch non_etch_y_grids 0.01 \n")
		fprintf(p "FORM grid all_etch all_etch_x_grids 0.01 \n")
		fprintf(p "FORM grid all_etch all_etch_y_grids 0.01 \n")
		fprintf(p "FORM grid done  \n")
		fprintf(p "setwindow pcb\n")
		;设置颜色
		fprintf(p "color192 \n")
		fprintf(p "setwindow cvf.dialog\n")
		fprintf(p "cvf layer_mode\n")
		fprintf(p "setwindow pcb\n")
		fprintf(p "setwindow cvf.dialog\n")
		fprintf(p "cvf layer_tree_item 'Display'\n")
		fprintf(p "cvf select_color_cell 8\n")
		fprintf(p "cvf tmp_hlt_clr 8\n")
		fprintf(p "cvf layer_tree_item 'Stack-Up'\n")
		fprintf(p "cvf select_color_cell 1\n")
		fprintf(p "cvf layers_color stack-up pin/top 81\n")
		fprintf(p "cvf layers_color stack-up via/top 81\n")
		fprintf(p "cvf layers_color stack-up etch/top 81\n")
		fprintf(p "cvf select_color_cell 6\n")
		fprintf(p "cvf layers_color stack-up pin/bottom 7\n")
		fprintf(p "cvf layers_color stack-up via/bottom 7\n")
		fprintf(p "cvf layers_color stack-up etch/bottom 7\n")
		fprintf(p "cvf layer_tree_item 'Package Geometry'\n")
		fprintf(p "cvf select_color_cell 7\n")
		fprintf(p "cvf layers_color package_geometry/silkscreen_bottom 8\n")
		fprintf(p "cvf select_color_cell 4\n")
		fprintf(p "cvf layers_color package_geometry/silkscreen_top 65\n")
		fprintf(p "cvf select_color_cell 3\n")
		fprintf(p "cvf layers_color package_geometry/display_top 4\n")
		fprintf(p "cvf select_color_cell 2\n")
		fprintf(p "cvf layers_color package_geometry/display_bottom 3\n")
		fprintf(p "cvf layer_tree_item 'Ref Des' 'Components'\n")
		fprintf(p "cvf layers_color components ref_des/silkscreen_top 65\n")
		fprintf(p "cvf select_color_cell 7\n")
		fprintf(p "cvf layers_color components ref_des/silkscreen_bottom 8\n")
		fprintf(p "cvf layer_tree_item 'Board Geometry'\n")
		fprintf(p "cvf select_color_cell 64\n")
		fprintf(p "cvf layers_color board_geometry/silkscreen_top 65\n")
		fprintf(p "cvf select_color_cell 7\n")
		fprintf(p "cvf layers_color board_geometry/silkscreen_bottom 8\n")
		fprintf(p "cvf okay\n")

		fprintf(p "setwindow pcb\n")
		close(p)
	axlShell("replay setupall.scr")
	deleteFile("setupall.scr")	;运行后删除产生的脚本文件
)

axlSetAlias( "~0" "setupall")	;设置快捷键 Ctrl键+0
